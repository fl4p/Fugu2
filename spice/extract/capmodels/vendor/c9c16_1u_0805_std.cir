* MMASH21GBC7105_TCA01     SPICE MODEL  ( Standard Model )
*--------------------------------------------------------------------------------------------------------
* Model Generated by TAIYO YUDEN Corporation (https://www.yuden.co.jp/en/)
* Version 1.0
* TAIYO YUDEN Control No. 220601
* Copyright(c) 2016 TAIYO YUDEN CO.,LTD. All Rights Reserved.
*--------------------------------------------------------------------------------------------------------
*
* Product Description (link to TY-COMPAS)
* https://ds.yuden.co.jp/TYCOMPAS/or/detail?pn=MMASH21GBC7105KTCA01&u=M
*
* Products Name : Multilayer Ceramic Capacitors
*
* Characteristics :
*     Capacitance : 1 [uF] , Rated Voltage : 100 [V] , TCC : X7S
*     Case Size : 2.0 x 1.25 / 0.079 x 0.049 [mm/inch] , Thickness : 1.25 / 0.049 [mm/inch]
*     (Conditions: Temperature = 25 [degC] , DC Bias Voltage = 0 [V])
*
* Frequency Range : 1kHz - 3GHz
*
* External Node Assignments :
*
*  1  o---| |---o  2
*
*--------------------------------------------------------------------------------------------------------
.SubCkt MMASH21GBC7105_TCA01 1 2
****************************
C0 1 110 0.97658u
C2m 1 301 0.027559u
C21 301 302 0.34188u
Rc21 301 302 2.4365k
C22 302 303 0.16949u
Rc22 302 303 1.3975k
C23 303 304 0.14317u
Rc23 303 304 1.0594k
C24 304 305 0.084942u
Rc24 304 305 441.3
C25 305 306 0.086043u
Rc25 305 306 144.43
C26 306 307 0.04335u
Rc26 306 307 87.274
C27 307 308 0.065644u
Rc27 307 308 20.779
C28 308 309 1879.6p
Rc28 308 309 21.565
C29 309 110 467.06p
Rc29 309 110 81.59
Rp0 1 110 100Meg
L0 110 120 0.1324n
Lm 120 130 0.24911n
L1 120 121 0.16184n
RL1 121 130 0.26473
L2 120 122 0.31591n
RL2 122 130 0.11687
L3 120 123 1.1998n
RL3 123 130 0.42891
CR 120 124 0.059341u
LR 124 125 1.0228n
RR 125 130 0.11145
CL 130 140 22.329p
LL 130 140 0.093384n
RL 130 140 3.7719
Rs 140 2 5.262m
****************************
.ends MMASH21GBC7105_TCA01
